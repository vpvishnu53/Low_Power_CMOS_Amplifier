// Sld_80/Low_AmpSd/schematic
subckt Low_AmpSd out vdd vin\+ vin\- vss
    M15 (out net28 net48 vdd) g45p2svt w=(640n) l=300n nf=1 m=(1)
    M14 (b4 net28 vdd vdd) g45p2svt w=(320n) l=150n nf=1 m=(1)
    M13 (net28 net28 vdd vdd) g45p2svt w=(320n) l=150n nf=1 m=(1)
    M12 (net48 b3 vdd vdd) g45p2svt w=(640n) l=300n nf=1 m=(1)
    M11 (b3 b3 vdd vdd) g45p2svt w=(320n) l=150n nf=1 m=(1)
    M7 (net14 b2 vdd vdd) g45p2svt w=(320n) l=150n nf=1 m=(1)
    M8 (b2 b2 vdd vdd) g45p2svt w=(320n) l=150n nf=1 m=(1)
    M6 (net39 net14 vss vss) g45n2svt w=(640n) l=300n nf=1 m=(1)
    M5 (out b4 net39 vss) g45n2svt w=(640n) l=300n nf=1 m=(1)
    M4 (vss b4 b4 vss) g45n2svt w=(320n) l=150n nf=1 m=(1)
    M3 (net28 b1 vss vss) g45n2svt w=(320n) l=150n nf=1 m=(1)
    M2 (net14 net14 vss vss) g45n2svt w=(320n) l=150n nf=1 m=(1)
    M1 (b1 b1 vss vss) g45n2svt w=(320n) l=150n nf=1 m=(1)
    M0 (b1 b1 vss vss) g45n2svt w=(320n) l=150n nf=1 m=(1)
    M10 (b3 vin\+ b1 vss) g45n2svt w=(1.6u) l=150n nf=1 m=(1)
    M9 (b2 vin\- b1 vss) g45n2svt w=(1.6u) l=150n nf=1 m=(1)
    I0 (vdd b1) isource dc=2u type=dc
    C0 (out vss) capacitor c=1p
ends Low_AmpSd

// Sld_80/low_amp1/schematic
I0 (out net2 net1 net3 0) Low_AmpSd
V3 (net3 0) vsource dc=1 type=dc
V2 (net1 0) vsource dc=1.028V mag=1 type=dc
V0 (net2 0) vsource dc=2 type=dc
simulatorOptions options temp=27
