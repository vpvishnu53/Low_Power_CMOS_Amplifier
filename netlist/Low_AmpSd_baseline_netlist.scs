// Reference: corrected BASELINE netlist of Sld_80/Low_AmpSd (Fig. 2 op-amp), as generated by Spectre
// after the fixes (Ibias dc=2u, diode ties b1..b4, input pair M9/M10 changed to NMOS, bodies on vss).
// Net names: b1 = Ibias/bias node (also tail node, as in the paper's drawing), b2 = M8 diode, b3 = M11 diode,
// b4 = M14 drain / M4 diode / M5 gate.  Test bench values used: VDD=2 V, V2 (vin+) = 1.028 V (AC mag 1), V3 (vin-) = 1 V.
// Baseline sizes: every transistor w=320n l=150n m=1.
// This file is for reference and for checking against a fresh netlist. The master copy is the Virtuoso schematic.
subckt Low_AmpSd out vdd vin\+ vin\- vss
    M15 (out net28 net48 vdd) g45p2svt w=(320n) l=150n nf=1 as=48f ad=48f \
        ps=940n pd=940n nrd=468.75m nrs=468.75m sa=150n sb=150n sd=200n \
        sca=24.37763 scb=0.02712 scc=0.00086 m=(1)
    M14 (b4 net28 vdd vdd) g45p2svt w=(320n) l=150n nf=1 as=48f ad=48f \
        ps=940n pd=940n nrd=468.75m nrs=468.75m sa=150n sb=150n sd=200n \
        sca=24.37763 scb=0.02712 scc=0.00086 m=(1)
    M13 (net28 net28 vdd vdd) g45p2svt w=(320n) l=150n nf=1 as=48f ad=48f \
        ps=940n pd=940n nrd=468.75m nrs=468.75m sa=150n sb=150n sd=200n \
        sca=24.37763 scb=0.02712 scc=0.00086 m=(1)
    M12 (net48 b3 vdd vdd) g45p2svt w=(320n) l=150n nf=1 as=48f ad=48f \
        ps=940n pd=940n nrd=468.75m nrs=468.75m sa=150n sb=150n sd=200n \
        sca=24.37763 scb=0.02712 scc=0.00086 m=(1)
    M11 (b3 b3 vdd vdd) g45p2svt w=(320n) l=150n nf=1 as=48f ad=48f \
        ps=940n pd=940n nrd=468.75m nrs=468.75m sa=150n sb=150n sd=200n \
        sca=24.37763 scb=0.02712 scc=0.00086 m=(1)
    M7 (net14 b2 vdd vdd) g45p2svt w=(320n) l=150n nf=1 as=48f ad=48f \
        ps=940n pd=940n nrd=468.75m nrs=468.75m sa=150n sb=150n sd=200n \
        sca=24.37763 scb=0.02712 scc=0.00086 m=(1)
    M8 (b2 b2 vdd vdd) g45p2svt w=(320n) l=150n nf=1 as=48f ad=48f ps=940n \
        pd=940n nrd=468.75m nrs=468.75m sa=150n sb=150n sd=200n \
        sca=24.37763 scb=0.02712 scc=0.00086 m=(1)
    M6 (net39 net14 vss vss) g45n2svt w=(320n) l=150n nf=1 as=48f ad=48f \
        ps=940n pd=940n nrd=468.75m nrs=468.75m sa=150n sb=150n sd=200n \
        sca=114.17432 scb=0.08203 scc=0.01268 m=(1)
    M5 (out b4 net39 vss) g45n2svt w=(320n) l=150n nf=1 as=48f ad=48f \
        ps=940n pd=940n nrd=468.75m nrs=468.75m sa=150n sb=150n sd=200n \
        sca=114.17432 scb=0.08203 scc=0.01268 m=(1)
    M4 (vss b4 b4 vss) g45n2svt w=(320n) l=150n nf=1 as=48f ad=48f ps=940n \
        pd=940n nrd=468.75m nrs=468.75m sa=150n sb=150n sd=200n \
        sca=114.17432 scb=0.08203 scc=0.01268 m=(1)
    M3 (net28 b1 vss vss) g45n2svt w=(320n) l=150n nf=1 as=48f ad=48f \
        ps=940n pd=940n nrd=468.75m nrs=468.75m sa=150n sb=150n sd=200n \
        sca=114.17432 scb=0.08203 scc=0.01268 m=(1)
    M2 (net14 net14 vss vss) g45n2svt w=(320n) l=150n nf=1 as=48f ad=48f \
        ps=940n pd=940n nrd=468.75m nrs=468.75m sa=150n sb=150n sd=200n \
        sca=114.17432 scb=0.08203 scc=0.01268 m=(1)
    M1 (b1 b1 vss vss) g45n2svt w=(320n) l=150n nf=1 as=48f ad=48f ps=940n \
        pd=940n nrd=468.75m nrs=468.75m sa=150n sb=150n sd=200n \
        sca=114.17432 scb=0.08203 scc=0.01268 m=(1)
    M0 (b1 b1 vss vss) g45n2svt w=(320n) l=150n nf=1 as=48f ad=48f ps=940n \
        pd=940n nrd=468.75m nrs=468.75m sa=150n sb=150n sd=200n \
        sca=114.17432 scb=0.08203 scc=0.01268 m=(1)
    M10 (b3 vin\+ b1 vss) g45n2svt w=(320n) l=150n nf=1 as=48f ad=48f \
        ps=940n pd=940n nrd=468.75m nrs=468.75m sa=150n sb=150n sd=200n \
        sca=114.17432 scb=0.08203 scc=0.01268 m=(1)
    M9 (b2 vin\- b1 vss) g45n2svt w=(320n) l=150n nf=1 as=48f ad=48f \
        ps=940n pd=940n nrd=468.75m nrs=468.75m sa=150n sb=150n sd=200n \
        sca=114.17432 scb=0.08203 scc=0.01268 m=(1)
    I0 (vdd b1) isource dc=2u type=dc
    C0 (out vss) capacitor c=1p
ends Low_AmpSd
